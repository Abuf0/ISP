addrmap regmap {
name = "isp_top";
default accesswidth = 16;
default regwidth = 16;
littleendian;
	regfile isp_config{
		reg {
			field {
				sw = rw;
				hw = r;
				desc = "ISP enable config";
			} rg_isp_enable[15:0] = 0x0;
		} isp_enable_cfg;
		reg {
			field {
				sw = rw;
				hw = w;
				desc = "input bayer img pattern:<br/>
						00: RGGB<br/>
						01: TODO...";
			} rg_bayer_pattern[1:0] = 0x0;
		} bayer_pattern_cfg;
		reg {
			field {
				sw = rw;
				hw = r;
				desc = "Dead Pixel Correction threshold value";
			} rg_dpc_thres[15:0] = 0x0;
		} dpc_thres_cfg;
		reg {
			field {
				sw = rw;
				hw = r;
				desc = "Dead Pixel Correction up-clip value";
			} rg_dpc_clip[15:0] = 0x00ff;
		} dpc_clip_cfg;
		reg {
			field {
				sw = rw;
				hw = r;
				desc = "Black Level Cancel bias value for channel_0";
			} rg_blc_bias_0[15:0] = 0x0;
		} blc_bias_0_cfg;
		reg {
			field {
				sw = rw;
				hw = r;
				desc = "Black Level Cancel bias value for channel_1";
			} rg_blc_bias_1[15:0] = 0x0;
		} blc_bias_1_cfg;
		reg {
			field {
				sw = rw;
				hw = r;
				desc = "Black Level Cancel bias value for channel_2";
			} rg_blc_bias_2[15:0] = 0x0;
		} blc_bias_2_cfg;
		reg {
			field {
				sw = rw;
				hw = r;
				desc = "Black Level Cancel bias value for channel_3";
			} rg_blc_bias_3[15:0] = 0x0;
		} blc_bias_3_cfg;
		reg {
			field {
				sw = rw;
				hw = r;
				desc = "Black Level Cancel up-clip value";
			} rg_blc_clip[15:0] = 0x00ff;
		} blc_clip_cfg;
		reg {
			field {
				sw = rw;
				hw = r;
				desc = "AWB gain value for channel_0";
			} rg_awb_gain_0[15:0] = 0x100;
		} awb_gain_0_cfg;
		reg {
			field {
				sw = rw;
				hw = r;
				desc = "AWB gain value for channel_1";
			} rg_awb_gain_1[15:0] = 0x100;
		} awb_gain_1_cfg;
		reg {
			field {
				sw = rw;
				hw = r;
				desc = "AWB gain value for channel_2";
			} rg_awb_gain_2[15:0] = 0x100;
		} awb_gain_2_cfg;
		reg {
			field {
				sw = rw;
				hw = r;
				desc = "AWB gain value for channel_3";
			} rg_awb_gain_3[15:0] = 0x100;
		} awb_gain_3_cfg;
		reg {
			field {
				sw = rw;
				hw = r;
				desc = "AWB gain up-clip value";
			} rg_awb_clip[15:0] = 0x00ff;
		} awb_clip_cfg;
		reg {
			field {
				sw = rw;
				hw = r;
				desc = "CNF gain value for channel_0";
			} rg_cnf_gain_0[15:0] = 0x100;
		} cnf_gain_0_cfg;
		reg {
			field {
				sw = rw;
				hw = r;
				desc = "CNF gain value for channel_1";
			} rg_cnf_gain_1[15:0] = 0x100;
		} cnf_gain_1_cfg;
		reg {
			field {
				sw = rw;
				hw = r;
				desc = "CNF gain value for channel_2";
			} rg_cnf_gain_2[15:0] = 0x100;
		} cnf_gain_2_cfg;
		reg {
			field {
				sw = rw;
				hw = r;
				desc = "CNF gain value for channel_3";
			} rg_cnf_gain_3[15:0] = 0x100;
		} cnf_gain_3_cfg;
		reg {
			field {
				sw = rw;
				hw = r;
				desc = "CNF gain up-clip value";
			} rg_cnf_clip[15:0] = 0x00ff;
		} cnf_clip_cfg;
		reg {
			field {
				sw = rw;
				hw = r;
				desc = "CNF threshold value";
			} rg_cnf_thres[15:0] = 0x0;
		} cnf_thres_cfg;

	} isp_config @0x0000;
};
